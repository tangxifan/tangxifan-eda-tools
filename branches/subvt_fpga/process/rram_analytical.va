// Analytical VerilogA model for RRAM in NonVolatileFlipFlops, Memristor, veriloga

`include "constants.vams"
`include "disciplines.vams"

module rram_analytical(te, be);
// Generic RRAM device parameters
parameter integer initial_state = 0; // 0: HRS; 1: LRS;
parameter real Vset_min = 1.2; // [V] Minimum voltage that RRAM set process will be invoked
parameter real Vreset_min = -1.2; // [V] Minimum voltage that RRAM reset process will be invoked
parameter real Iset_max = 500e-6; // [A] Maximum current for set process
parameter real Ireset_max = 500e-6; // [A] Maximum current for set process
parameter real Rhrs = 20e6; // [Ohm] High resistance state
// Gap of RRAM device, modelling the filament growth
parameter real gap_ini = 0 from (0:1); // [Ohm]

inout te, be; // te: Top Electrode; be: Bottom Electrode;
electrical te, be; //External Nodes

// Local parameters
real Vtb, Itb; // Present Voltage/Current across Top Electrode and Bottom Electrode
real res;
real state; // 0: Reset; 1: Set; 2: Reset Process; 3: Set Process;
real gap, gap_min;

analog begin : rram_module
  // Present Vtb, Itb
  Vtb = V(te, be);
  Itb = I(te, be);

  @(initial_step)
  begin
    state=initial_state; // determine the initial_state
    gap_min = Vset_min/Rhrs/Iset_max;
    gap = gap_min + gap_ini*(1 - gap_min); // determine the gap
    // Print Gap:
    $stobe("CurrentGap=%g\n", gap);
  end

  if ((Vreset_min < Vtb) && (Vtb < Vset_min))
  begin
    // The voltage does not meet the threshold, stay in the original state
    if (2 == state) // Reset process: stop to HRS
      state = 0;
    if (3 == state) // Set process: stop to LRS
      state = 1;
    // Otherwise, stay in the original state
  end
  else if (Vtb < Vreset_min) // May change from HRS to LRS;
  begin
    if (abs(Itb) > gap) // Start Reset Process, only the current is sufficent
      state = 2;
    // Otherwise, stay in the original state
  end
  else if (Vset_min < Vtb)
  begin
    state = 3; // Start Set Process
  end

  // Determine the resistance according to the state
  if (0 == state) // HRS
    res = Rhrs;
  else if (1 == state) // LRS
    res = Vset_min/(gap*Iset_max);
  else if (2 == state) // Reset Process
    res = Rhrs;
  else if (3 == state) // Set Process
    res = Vset_min/Itb;
    gap = (Itb - gap_min*Iset_max)/(Iset_max*(1-gap_min))
    // Print Gap:
    $stobe("CurrentGap=%g\n", gap);
  else
   $stobe("Warning: State is not deterministic!\n");

  I(te,be) <+ V(te,be) / res;
end
endmodule
